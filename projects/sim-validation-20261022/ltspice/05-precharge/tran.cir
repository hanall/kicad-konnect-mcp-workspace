* 05 precharge inrush
V1 in 0 PULSE(0 48 0 1u 1u 10 20)
RPRE in bus 47
CBUS bus 0 4700u
B1 p 0 V=i(V1)*i(V1)*47
B2 ia 0 V=-i(V1)
.tran 100u 3
.meas tran i_pk MAX V(ia) FROM 0 TO 3
.meas tran p_pk MAX V(p) FROM 0 TO 3
.meas tran v_bus_at_tau FIND V(bus) AT 0.2209
.meas tran t_95 WHEN V(bus)=45.6 RISE=1
.meas tran e_r INTEG V(p) FROM 0 TO 3
.end
