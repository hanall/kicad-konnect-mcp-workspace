.title KiCad schematic
.include "/opt/kicad/10.0.6/share/kicad/symbols/Simulation_SPICE.sp"
R1 inn GND 1k
R2 out inn 9k
XU1 in inn vcc vee out kicad_builtin_opamp POLE=20 GAIN=20k VOFF=0 ROUT=10
V3 in GND DC 0 SIN( 0 0.1 1k 0 0 0 ) AC 1
V1 vcc GND DC 15
V2 GND vee DC 15
.save all
.ac dec 100 1 10meg
.meas ac gain_db_10hz FIND vdb(out) AT=10
.meas ac f_3db WHEN vdb(out)=16.9957 FALL=1
.end
