.title KiCad schematic
.model __D1 D
+           is=10f
+           rs=0
+           n=1
+           cjo=0
.tran 1u 2m
D1 in out __D1
R1 out GND 1k
V1 in GND DC 0 SIN( 0 10 1k )
.end
