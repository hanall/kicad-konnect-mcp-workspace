* Qucs 26.1.1  /home/hanol/kicad-konnect-mcp-workspace/projects/sim-validation-20261022/qucs-s/01-rc-step/01-rc-step.sch
.INCLUDE "/tmp/.mount_Qucs-SbfidHI/usr/share/qucs-s/xspice_cmlib/include/ngspice_mathfunc.inc"
V1 in  0 PULSE(0 5 0 1n 1n 10m 20m)
R1 in  out 1k
C1 out  0 1u

.control

tran 1e-06 0.005 0
write spice4qucs.tr1.plot v(in) v(out)
destroy all
reset

exit
.endc
.END
